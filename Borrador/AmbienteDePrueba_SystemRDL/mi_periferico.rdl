mem my_memory {
    memwidth = 32;
    mementries = 256;
    sw = rw;
};

addrmap MI_PERIFERICO{
    name = "Registro de control del Periférico";
    desc = "Un periférico de ejemplo";
    littleendian;
    external my_memory my_mem_inst[1024] @ 0x1000;

    reg {
        name = "Registro de Control";

        field {
            sw = rw;
            hw = r;
            reset = 0;
        } ENABLE[1] = 0;

        field {
            sw = rw;
            hw = r;
            reset = 1;
        } MODE[2] = 1;

    } CONTROL @0x04;

    reg {
        name = "Registro de Estado";

        field {
            sw = r;
            hw = w;
            reset = 1;
        } READY[1] = 1;

        field {
            sw = rw;
            hw = w;
            reset = 0;
            onwrite = woclr;
        } ERROR[1] = 0;

    } STATUS @0x08;

};