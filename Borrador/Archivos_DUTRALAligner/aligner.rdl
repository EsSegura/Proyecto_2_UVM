addrmap aligner{
    name = "Registros de estado y control del aligner";
    desc = "Registros de un aligner de entradas de hasta 4 bytes";
    littleendian;

    reg {
        name = "Registro de solicitud de interrupciones";

        field {
            sw = rw;
            hw = r;
            reset = 0;
        } RX_FIFO_EMPTY[0:0] ;

        field {
            sw = rw;
            hw = r;
            reset = 0;
        } RX_FIFO_FULL[1:1];

        field {
            sw = rw;
            hw = r;
            reset = 0;
        } TX_FIFO_EMPTY[2:2];

        field {
            sw = rw;
            hw = r;
            reset = 0;
        } TX_FIFO_FULL[3:3] ;

        field {
            sw = rw;
            hw = r;
            reset = 0;
        } MAX_DROP[4:4];

    // Bits reservados
    field {
        sw = r;
        hw = na;
        reset = 0;
    } reserved[31:5];

    } IRQ @0x00F4;

    reg {
        name = "Registro de habilitación de interrupciones ";

        field {
            sw = rw;
            hw = r;
            reset = 1;
            onwrite = woclr;
        } RX_FIFO_EMPTY[0:0] ;

        field {
            sw = rw;
            hw = r;
            reset = 1;
            onwrite = woclr;
        } RX_FIFO_FULL[1:1];

        field {
            sw = rw;
            hw = r;
            reset = 1;
            onwrite = woclr;
        } TX_FIFO_EMPTY[2:2];

        field {
            sw = rw;
            hw = r;
            reset = 1;
            onwrite = woclr;
        } TX_FIFO_FULL[3:3] ;

        field {
            sw = rw;
            hw = r;
            reset = 1;
            onwrite = woclr;
        } MAX_DROP[4:4];

        // Bits reservados
        field {
            sw = r;
            hw = na;
            reset = 0;
        } reserved[31:5];


    } IRQEN @0x00F0;

    reg {
        name = "Registro de estado";

        field {
            sw = r;
            hw = w;
            reset = 0; 
        } CNT_DROP[7:0];

        field {
            sw = r;
            hw = w;
            reset = 0;
        } RX_LVL[11:9];

        // Bits reservados
        field {
            sw = r;
            hw = na;
            reset = 0;
        } reserved1[15:12];

        field {
            sw = r;
            hw = w;
            reset = 0;
        } TX_LVL[19:16];

        // Bits reservados
        field {
            sw = r;
            hw = na;
            reset = 0;
        } reserved2[31:20];

    } STATUS @0x00C;

    reg {
        name = "Registro de control";

        field {
            sw = rw;
            hw = na; // se pone na porque el hardware no deberia de poder escribirlo ni leerlo
            reset = 1; // esto segun el rtl
        } SIZE[2:0];

        // Bits reservados
        field {
            sw = r;
            hw = na;
            reset = 0;
        } reserved1[7:3];

        field {
            sw = rw;
            hw = na; // se pone na porque el hardware no deberia de poder escribirlo ni leerlo
            reset = 0; 
        } OFFSET[9:8];

        // Bits reservados
        field {
            sw = r;
            hw = na;
            reset = 0;
        } reserved2[15:10];

        field {
            sw = w;
            hw = na; // se pone na porque el hardware no deberia de poder escribirlo ni leerlo
            reset = 0;
        } CLR[16:16];

        // Bits reservados
        field {
            sw = r;
            hw = na;
            reset = 0;
        } reserved3[31:17];

    } CTRL @0x0000;


};